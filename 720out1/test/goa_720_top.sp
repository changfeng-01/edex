* 720-stage 4-phase GOA top netlist
* Generated automatically.
* Subckt pin order detected from 8T1C.netlist: clk clkb input output reset vss

.INCLUDE "8T1C.netlist"
.INCLUDE "goa_720_instances.sp"
.INCLUDE "goa_720_load.sp"

.OPTION POST=2

VVSS VSS 0 DC -5

VCK1 CK1 0 PULSE(-5 15 5.250000u 0.200000u 0.200000u 20.000000u 88.888889u)
VCK2 CK2 0 PULSE(-5 15 27.472222u 0.200000u 0.200000u 20.000000u 88.888889u)
VCK3 CK3 0 PULSE(-5 15 49.694444u 0.200000u 0.200000u 20.000000u 88.888889u)
VCK4 CK4 0 PULSE(-5 15 71.916667u 0.200000u 0.200000u 20.000000u 88.888889u)

VSTV STV 0 PULSE(-5 15 0.250000u 0.200000u 0.200000u 5.000000u 16666.666667u)
VRESETEND RESET_END 0 PULSE(-5 15 16027.472222u 0.200000u 0.200000u 20.000000u 16666.666667u)

.PROBE TRAN V(STV) V(CK1) V(CK2) V(CK3) V(CK4) V(RESET_END) V(OUT001) V(OUT002) V(OUT003) V(OUT004) V(OUT359) V(OUT360) V(OUT361) V(OUT362) V(OUT717) V(OUT718) V(OUT719) V(OUT720) V(OUT721)

.TRAN 100n 17166.666667u

.END
