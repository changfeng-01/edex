*************************************************************
*** EsimFPD Model ver: 2021.10                            ***
***       Built at: 01/14/2022 17:17                      ***
***   (C) Copyright 2022 Huada Empyrean Software Co.      ***
*************************************************************

********************************************************
** Info of measurement used for model card generation **
** W / L = 10um / 4um @ T = 27C
********************************************************

.model aa_tft  nmos
