*************************************************************
*** EsimFPD Model ver: 2021.10                            ***
***       Built at: 01/14/2022 17:17                      ***
***   (C) Copyright 2022 Huada Empyrean Software Co.      ***
*************************************************************

********************************************************
** Info of measurement used for model card generation **
** W / L = 20-50000um / 3.5um @ T = 27C
********************************************************

.model m_goa_tft.1 nmos
*--------------------------------------------------------------------*
*                           Model Selector                           *
*--------------------------------------------------------------------*
+ level = 302                     version = 2                     capmod = 0
+ shmod = 0                       geomod = 0                      tempmod = 1
+ vfbmod = 1                      leakmod = 3                     acm = 0
+ wmin = 2e-05                    wmax = 5e-05                    lmin = 3.5e-06
+ lmax = 3.96E-6
*--------------------------------------------------------------------*
*                         Process Parameter                          *
*--------------------------------------------------------------------*
+ tox = 4e-07                     l = 3.5e-06                     w = 2e-05
+ eps = 11                        epsi = 6.9
*--------------------------------------------------------------------*
*                         Geometry Parameter                         *
*--------------------------------------------------------------------*
+ del = 0                         xj = 0                          ld = 0
+ wd = 0                          ldif = 0                        hdif = 0
+ xl = 9.998e-09                  xw = 6.60827e-06                geo = 0
*--------------------------------------------------------------------*
*                    Series Resistance Parameter                     *
*--------------------------------------------------------------------*
+ rd = 0.0                        rs = 0.0                        rdc = 0
+ rsc = 0                         rsh = 0
*--------------------------------------------------------------------*
*                          Id-Vd Parameter                           *
*--------------------------------------------------------------------*
+ lambda = 0.0034275159094931105  wlambda = -0.05287930437778825  lambdag = 0
+ alphasat = 1.0571278336540404   walphasat = -3.6458341209517915  asatg = -0
+ kink = 0                        mkink = 1.3                     vkinkg = 0
+ vkink = 9.1                     lkink = 1.9e-05                 m = 3.3489978966590312
+ wm = -25.720828229235593
*--------------------------------------------------------------------*
*                          Id-Vg Parameter                           *
*--------------------------------------------------------------------*
+ vmin = 0.5859315351191513       wvmin = -2.876474658674859      delta = 7.601944346366984
+ wdelta = 20.860501947993786     delvto = 0                      muband = 5.2585091E-4
+ wmuband = 0.0020933281272251542  mubandg = 0                     mubandd = 0
+ vaa = 6201.458375603069         wvaa = 214658.0041241921        gamma = 0.4206930477795337
+ wgamma = 0.6793078617692662     gammad = 0
*--------------------------------------------------------------------*
*                           Vth Parameter                            *
*--------------------------------------------------------------------*
+ vt_estmod = 3                   vfb = -3.240046178789482        wvfb = -14.860820470801192
+ vti_max = 0                     v0 = 0.17126603879672236        wv0 = -0.1756954391236636
+ gmin = 6.3668412E22             wgmin = 2.5345143E23            def0 = 0.6
+ vt0 = 1.97476472061598          wvt0 = -17.52034098892456       dibl = 0.015453
+ dibld = 0.1                     nibl = 0                        nibld = 2e-05
*--------------------------------------------------------------------*
*                         Leakage Parameter                          *
*--------------------------------------------------------------------*
+ iol = 3.0619866E-13             wiol = 1.0361828E-11            vdsl = 5.668063904334418
+ wvdsl = 22.492398908815634      vgsl = 9.45709955413148         wvgsl = 42.575904690789955
+ vgsld = 0.000471721             ibcf = 0.1                      vdsbc = 0.1
+ mbc = 1                         mbcd = 0.15                     vfc = -19.458
+ ifcf = 0.703448                 mfc = 0.0331141                 mfcd = 0
+ sigma0 = 1.0E-14                sigma0d = 0.05                  ulc1a = 1e-16
+ ulc1b = 1e-15                   ulc1eaa = 0.025                 ulc1eab = 0.025
+ ulc2gamma = 1e-18               ulc2etad = 0.5                  ulc2etag = 0.15
*--------------------------------------------------------------------*
*                  Temperature Dependency Parameter                  *
*--------------------------------------------------------------------*
+ tnom = 27                       emu = 0.06                      kvt = -0.036
+ kasat = 0.006                   el = 0.35                       tvfb1 = -0.01
+ tvfb2 = 0.001                   ute = 1                         kgamma = 0.001
+ kv0 = 0.001                     kdibl = 1                       kiol = 0.01
+ ksigma0 = 0.01                  kifcf = 0.01                    kibcf = 0.01
+ tc = 390
*--------------------------------------------------------------------*
*                       Capacitance Parameter                        *
*--------------------------------------------------------------------*
+ leffcv = 1e-05                  weffcv = 1e-05                  dlc = 0
+ dwc = 0                         dvon = 0.1                      zeroc = 0
+ meto = 0                        cgso = 0.0                      cgdo = 0.0
+ capgamma = 0.5                  etac0 = 7.0                     etac00 = 0
+ mc = 3                          meascap = 0
*--------------------------------------------------------------------*
*                   Frequency Dispersion Parameter                   *
*--------------------------------------------------------------------*
+ kss = 0                         rdx = 0.0                       rsx = 0.0
*--------------------------------------------------------------------*
*                       Self-heating Parameter                       *
*--------------------------------------------------------------------*
+ cth0 = 0                        rth0 = 0
*--------------------------------------------------------------------*
*                          Noise Parameter                           *
*--------------------------------------------------------------------*
+ nlev = 0                        kf = 0                          af = 0
+ meaststep = 0                   hss = 0.01                      hmu0 = 0.01
+ hmu1 = 0.01                     hiol = 1                        hcox = 0
+ asp = 1                         bsp = 0.5                       dsp = 0.5
+ gsp = 0.5                       tsp = 10000                     asn = 0.1
+ bsn = 0.5                       dsn = 0.5                       gsn = 0.5
+ tsn = 10000
*--------------------------------------------------------------------*
*                               Other                                *
*--------------------------------------------------------------------*
+ lwdepmod = 0                    stresstimemod = 1               stressparammod = 1
+ tox2 = 0                        epsi2 = 0                       strmod = 0
+ hysadjustp = 1                  imageadjustp = 0.0001           gleveladjustp = 1
+ badjustp = 0.1                  tauadjustp = 0.0001             hysadjustn = 0.1
+ imageadjustn = 0.0001           gleveladjustn = 1               badjustn = 0.1
+ tauadjustn = 0.0001             asptemp = 0.025                 bsptemp = 1
+ tsptemp = 0.025                 asntemp = 0.025                 bsntemp = 1
+ tsntemp = 0.025                 acamplitude = 10                acexpadjust = 1
+ actau = 0.5

.model m_goa_tft.2 nmos
*--------------------------------------------------------------------*
*                           Model Selector                           *
*--------------------------------------------------------------------*
+ level = 302                     version = 2                     capmod = 0
+ shmod = 0                       geomod = 0                      tempmod = 1
+ vfbmod = 1                      leakmod = 3                     acm = 0
+ wmin = 5e-05                    wmax = 0.00027                  lmin = 3.5e-06
+ lmax = 3.96E-6
*--------------------------------------------------------------------*
*                         Process Parameter                          *
*--------------------------------------------------------------------*
+ tox = 4e-07                     l = 3.5e-06                     w = 5e-05
+ eps = 11                        epsi = 6.9
*--------------------------------------------------------------------*
*                         Geometry Parameter                         *
*--------------------------------------------------------------------*
+ del = 0                         xj = 0                          ld = 0
+ wd = 0                          ldif = 0                        hdif = 0
+ xl = 1.02989e-08                xw = 5.33647e-06                geo = 0
*--------------------------------------------------------------------*
*                    Series Resistance Parameter                     *
*--------------------------------------------------------------------*
+ rd = 0.0                        rs = 0.0                        rdc = 0
+ rsc = 0                         rsh = 0
*--------------------------------------------------------------------*
*                          Id-Vd Parameter                           *
*--------------------------------------------------------------------*
+ lambda = 0.009141736959585416   wlambda = -0.3690841260895896   lambdag = 0
+ alphasat = 1.2158686559928669   walphasat = -12.429990874079602  asatg = -0
+ kink = 0                        mkink = 1.3                     vkinkg = 0
+ vkink = 9.1                     lkink = 1.9e-05                 m = 1.7796154859448685
+ wm = 61.123254459776355
*--------------------------------------------------------------------*
*                          Id-Vg Parameter                           *
*--------------------------------------------------------------------*
+ vmin = 0.5809943644006634       wvmin = -2.603269059326376      delta = 8.271811929988779
+ wdelta = -16.207605497066215    delvto = 0                      muband = 7.5220623E-4
+ wmuband = -0.010432375876940564  mubandg = 0                     mubandd = 0
+ vaa = 12071.66371324527         wvaa = -110178.43743608553      gamma = 0.4383052873720921
+ wgamma = -0.29529130607715415   gammad = 0
*--------------------------------------------------------------------*
*                           Vth Parameter                            *
*--------------------------------------------------------------------*
+ vt_estmod = 3                   vfb = -4.624377020339732        wvfb = 61.74316161271894
+ vti_max = 0                     v0 = 0.16564961771729458        wv0 = 0.13509747744545894
+ gmin = 6.7282769E22             wgmin = 5.3445681E22            def0 = 0.6
+ vt0 = 4.554866715815555         wvt0 = -160.29407764322596      dibl = 0.0172189
+ dibld = 0.1                     nibl = 0                        nibld = 2e-05
*--------------------------------------------------------------------*
*                         Leakage Parameter                          *
*--------------------------------------------------------------------*
+ iol = 4.2875029E-13             wiol = 3.5802536E-12            vdsl = 6.372277581777704
+ wvdsl = -16.476300126614422     vgsl = 8.786146073150361        wvgsl = 79.70410186249724
+ vgsld = 0.000463471             ibcf = 0.1                      vdsbc = 0.1
+ mbc = 1                         mbcd = 0.15                     vfc = -19.9276
+ ifcf = 0.732303                 mfc = 0.0344725                 mfcd = 0
+ sigma0 = 1.0E-14                sigma0d = 0.05                  ulc1a = 1e-16
+ ulc1b = 1e-15                   ulc1eaa = 0.025                 ulc1eab = 0.025
+ ulc2gamma = 1e-18               ulc2etad = 0.5                  ulc2etag = 0.15
*--------------------------------------------------------------------*
*                  Temperature Dependency Parameter                  *
*--------------------------------------------------------------------*
+ tnom = 27                       emu = 0.06                      kvt = -0.036
+ kasat = 0.006                   el = 0.35                       tvfb1 = -0.01
+ tvfb2 = 0.001                   ute = 1                         kgamma = 0.001
+ kv0 = 0.001                     kdibl = 1                       kiol = 0.01
+ ksigma0 = 0.01                  kifcf = 0.01                    kibcf = 0.01
+ tc = 390
*--------------------------------------------------------------------*
*                       Capacitance Parameter                        *
*--------------------------------------------------------------------*
+ leffcv = 1e-05                  weffcv = 1e-05                  dlc = 0
+ dwc = 0                         dvon = 0.1                      zeroc = 0
+ meto = 0                        cgso = 0.0                      cgdo = 0.0
+ capgamma = 0.5                  etac0 = 7.0                     etac00 = 0
+ mc = 3                          meascap = 0
*--------------------------------------------------------------------*
*                   Frequency Dispersion Parameter                   *
*--------------------------------------------------------------------*
+ kss = 0                         rdx = 0.0                       rsx = 0.0
*--------------------------------------------------------------------*
*                       Self-heating Parameter                       *
*--------------------------------------------------------------------*
+ cth0 = 0                        rth0 = 0
*--------------------------------------------------------------------*
*                          Noise Parameter                           *
*--------------------------------------------------------------------*
+ nlev = 0                        kf = 0                          af = 0
+ meaststep = 0                   hss = 0.01                      hmu0 = 0.01
+ hmu1 = 0.01                     hiol = 1                        hcox = 0
+ asp = 1                         bsp = 0.5                       dsp = 0.5
+ gsp = 0.5                       tsp = 10000                     asn = 0.1
+ bsn = 0.5                       dsn = 0.5                       gsn = 0.5
+ tsn = 10000
*--------------------------------------------------------------------*
*                               Other                                *
*--------------------------------------------------------------------*
+ lwdepmod = 0                    stresstimemod = 1               stressparammod = 1
+ tox2 = 0                        epsi2 = 0                       strmod = 0
+ hysadjustp = 1                  imageadjustp = 0.0001           gleveladjustp = 1
+ badjustp = 0.1                  tauadjustp = 0.0001             hysadjustn = 0.1
+ imageadjustn = 0.0001           gleveladjustn = 1               badjustn = 0.1
+ tauadjustn = 0.0001             asptemp = 0.025                 bsptemp = 1
+ tsptemp = 0.025                 asntemp = 0.025                 bsntemp = 1
+ tsntemp = 0.025                 acamplitude = 10                acexpadjust = 1
+ actau = 0.5

.model m_goa_tft.3 nmos
*--------------------------------------------------------------------*
*                           Model Selector                           *
*--------------------------------------------------------------------*
+ level = 302                     version = 2                     capmod = 0
+ shmod = 0                       geomod = 0                      tempmod = 1
+ vfbmod = 1                      leakmod = 3                     acm = 0
+ wmin = 0.00027                  wmax = 0.00036                  lmin = 3.5e-06
+ lmax = 3.96E-6
*--------------------------------------------------------------------*
*                         Process Parameter                          *
*--------------------------------------------------------------------*
+ tox = 4e-07                     l = 3.5e-06                     w = 0.00027
+ eps = 11                        epsi = 6.9
*--------------------------------------------------------------------*
*                         Geometry Parameter                         *
*--------------------------------------------------------------------*
+ del = 0                         xj = 0                          ld = 0
+ wd = 0                          ldif = 0                        hdif = 0
+ xl = 9.50325e-09                xw = 2.34463e-05                geo = 0
*--------------------------------------------------------------------*
*                    Series Resistance Parameter                     *
*--------------------------------------------------------------------*
+ rd = 0.0                        rs = 0.0                        rdc = 0
+ rsc = 0                         rsh = 0
*--------------------------------------------------------------------*
*                          Id-Vd Parameter                           *
*--------------------------------------------------------------------*
+ lambda = 0.005111612183167363   wlambda = 0.8135410780886152    lambdag = 0
+ alphasat = 1.5084114392359094   walphasat = -98.2755882084524   asatg = -0
+ kink = 0                        mkink = 1.3                     vkinkg = 0
+ vkink = 9.1                     lkink = 1.9e-05                 m = 1.4355614875759932
+ wm = 162.0846272813289
*--------------------------------------------------------------------*
*                          Id-Vg Parameter                           *
*--------------------------------------------------------------------*
+ vmin = 0.8974946565208101       wvmin = -95.47910873090258      delta = 2.3623529354618977
+ wdelta = 1717.9012714485675     delvto = 0                      muband = 6.2956498E-4
+ wmuband = 0.025556245251403688  mubandg = 0                     mubandd = 0
+ vaa = 13722.411363798177        wvaa = -594584.2277245288       gamma = 0.4023427356587014
+ wgamma = 10.257786432776012     gammad = 0
*--------------------------------------------------------------------*
*                           Vth Parameter                            *
*--------------------------------------------------------------------*
+ vt_estmod = 3                   vfb = -3.893497251713793        wvfb = -152.7308022354188
+ vti_max = 0                     v0 = 0.18790000879239052        wv0 = -6.394197457094463
+ gmin = 1.1893561E23             wgmin = -1.510389E25            def0 = 0.6
+ vt0 = 7.162879239119233         wvt0 = -925.6057029603543       dibl = 0.0289189
+ dibld = 0.0970299               nibl = 0                        nibld = 2e-05
*--------------------------------------------------------------------*
*                         Leakage Parameter                          *
*--------------------------------------------------------------------*
+ iol = 3.3471493E-13             wiol = 3.1174583E-11            vdsl = 6.0508692806052
+ wvdsl = 77.83977664174229       vgsl = 8.251517319734212        wvgsl = 236.58893142607872
+ vgsld = 0.000469164             ibcf = 0.1                      vdsbc = 0.1
+ mbc = 1                         mbcd = 0.15                     vfc = -20.4446
+ ifcf = 0.754719                 mfc = 0.0377209                 mfcd = 0
+ sigma0 = 1.0E-14                sigma0d = 0.05                  ulc1a = 1e-16
+ ulc1b = 1e-15                   ulc1eaa = 0.025                 ulc1eab = 0.025
+ ulc2gamma = 1e-18               ulc2etad = 0.5                  ulc2etag = 0.15
*--------------------------------------------------------------------*
*                  Temperature Dependency Parameter                  *
*--------------------------------------------------------------------*
+ tnom = 27                       emu = 0.06                      kvt = -0.036
+ kasat = 0.006                   el = 0.35                       tvfb1 = -0.01
+ tvfb2 = 0.001                   ute = 1                         kgamma = 0.001
+ kv0 = 0.001                     kdibl = 1                       kiol = 0.01
+ ksigma0 = 0.01                  kifcf = 0.01                    kibcf = 0.01
+ tc = 390
*--------------------------------------------------------------------*
*                       Capacitance Parameter                        *
*--------------------------------------------------------------------*
+ leffcv = 1e-05                  weffcv = 1e-05                  dlc = 0
+ dwc = 0                         dvon = 0.1                      zeroc = 0
+ meto = 0                        cgso = 0.0                      cgdo = 0.0
+ capgamma = 0.5                  etac0 = 7.0                     etac00 = 0
+ mc = 3                          meascap = 0
*--------------------------------------------------------------------*
*                   Frequency Dispersion Parameter                   *
*--------------------------------------------------------------------*
+ kss = 0                         rdx = 0.0                       rsx = 0.0
*--------------------------------------------------------------------*
*                       Self-heating Parameter                       *
*--------------------------------------------------------------------*
+ cth0 = 0                        rth0 = 0
*--------------------------------------------------------------------*
*                          Noise Parameter                           *
*--------------------------------------------------------------------*
+ nlev = 0                        kf = 0                          af = 0
+ meaststep = 0                   hss = 0.01                      hmu0 = 0.01
+ hmu1 = 0.01                     hiol = 1                        hcox = 0
+ asp = 1                         bsp = 0.5                       dsp = 0.5
+ gsp = 0.5                       tsp = 10000                     asn = 0.1
+ bsn = 0.5                       dsn = 0.5                       gsn = 0.5
+ tsn = 10000
*--------------------------------------------------------------------*
*                               Other                                *
*--------------------------------------------------------------------*
+ lwdepmod = 0                    stresstimemod = 1               stressparammod = 1
+ tox2 = 0                        epsi2 = 0                       strmod = 0
+ hysadjustp = 1                  imageadjustp = 0.0001           gleveladjustp = 1
+ badjustp = 0.1                  tauadjustp = 0.0001             hysadjustn = 0.1
+ imageadjustn = 0.0001           gleveladjustn = 1               badjustn = 0.1
+ tauadjustn = 0.0001             asptemp = 0.025                 bsptemp = 1
+ tsptemp = 0.025                 asntemp = 0.025                 bsntemp = 1
+ tsntemp = 0.025                 acamplitude = 10                acexpadjust = 1
+ actau = 0.5

.model m_goa_tft.4 nmos
*--------------------------------------------------------------------*
*                           Model Selector                           *
*--------------------------------------------------------------------*
+ level = 302                     version = 2                     capmod = 0
+ shmod = 0                       geomod = 0                      tempmod = 1
+ vfbmod = 1                      leakmod = 3                     acm = 0
+ wmin = 0.00036                  wmax = 0.0007                   lmin = 3.5e-06
+ lmax = 3.96E-6
*--------------------------------------------------------------------*
*                         Process Parameter                          *
*--------------------------------------------------------------------*
+ tox = 4e-07                     l = 3.5e-06                     w = 0.00036
+ eps = 11                        epsi = 6.9
*--------------------------------------------------------------------*
*                         Geometry Parameter                         *
*--------------------------------------------------------------------*
+ del = 0                         xj = 0                          ld = 0
+ wd = 0                          ldif = 0                        hdif = 0
+ xl = 9.04111e-09                xw = 2.75504e-05                geo = 0
*--------------------------------------------------------------------*
*                    Series Resistance Parameter                     *
*--------------------------------------------------------------------*
+ rd = 0.0                        rs = 0.0                        rdc = 0
+ rsc = 0                         rsh = 0
*--------------------------------------------------------------------*
*                          Id-Vd Parameter                           *
*--------------------------------------------------------------------*
+ lambda = 0.007504584074753271   wlambda = -0.11385613568426019  lambdag = 0
+ alphasat = 0.5691809730200046   walphasat = 265.723554665708    asatg = -0
+ kink = 0                        mkink = 1.3                     vkinkg = 0
+ vkink = 9.1                     lkink = 1.9e-05                 m = 5.565693642028258
+ wm = -1438.549741229508
*--------------------------------------------------------------------*
*                          Id-Vg Parameter                           *
*--------------------------------------------------------------------*
+ vmin = 0.4653560993768918       wvmin = 71.99636194564582       delta = 7.729693899651966
+ wdelta = -362.2138661596796     delvto = 0                      muband = 6.2014218E-4
+ wmuband = 0.029208052731548362  mubandg = 0                     mubandd = 0
+ vaa = 7976.929252565881         wvaa = 1632079.6626763921       gamma = 0.322168916703639
+ wgamma = 41.32918203833802      gammad = 0
*--------------------------------------------------------------------*
*                           Vth Parameter                            *
*--------------------------------------------------------------------*
+ vt_estmod = 3                   vfb = -0.41271189140958464      wvfb = -1501.710560935459
+ vti_max = 0                     v0 = 0.24561493822650773        wv0 = -28.761641445258366
+ gmin = 5.8829315E22             wgmin = 8.1903291E24            def0 = 0.6
+ vt0 = 0.6170136202391854        wvt0 = 1611.2471359828558       dibl = 0.0343109
+ dibld = 0.1                     nibl = 0                        nibld = 2e-05
*--------------------------------------------------------------------*
*                         Leakage Parameter                          *
*--------------------------------------------------------------------*
+ iol = 8.4916776E-13             wiol = -1.6820182E-10           vdsl = 6.794397767359777
+ wvdsl = -210.31498581138848     vgsl = 9.406839882624942        wvgsl = -211.1567899512488
+ vgsld = 0.000487879             ibcf = 0.1                      vdsbc = 0.1
+ mbc = 1                         mbcd = 0.15                     vfc = -20.3357
+ ifcf = 0.754719                 mfc = 0.0377284                 mfcd = 0
+ sigma0 = 1.0E-14                sigma0d = 0.05                  ulc1a = 1e-16
+ ulc1b = 1e-15                   ulc1eaa = 0.025                 ulc1eab = 0.025
+ ulc2gamma = 1e-18               ulc2etad = 0.5                  ulc2etag = 0.15
*--------------------------------------------------------------------*
*                  Temperature Dependency Parameter                  *
*--------------------------------------------------------------------*
+ tnom = 27                       emu = 0.06                      kvt = -0.036
+ kasat = 0.006                   el = 0.35                       tvfb1 = -0.01
+ tvfb2 = 0.001                   ute = 1                         kgamma = 0.001
+ kv0 = 0.001                     kdibl = 1                       kiol = 0.01
+ ksigma0 = 0.01                  kifcf = 0.01                    kibcf = 0.01
+ tc = 390
*--------------------------------------------------------------------*
*                       Capacitance Parameter                        *
*--------------------------------------------------------------------*
+ leffcv = 1e-05                  weffcv = 1e-05                  dlc = 0
+ dwc = 0                         dvon = 0.1                      zeroc = 0
+ meto = 0                        cgso = 0.0                      cgdo = 0.0
+ capgamma = 0.5                  etac0 = 7.0                     etac00 = 0
+ mc = 3                          meascap = 0
*--------------------------------------------------------------------*
*                   Frequency Dispersion Parameter                   *
*--------------------------------------------------------------------*
+ kss = 0                         rdx = 0.0                       rsx = 0.0
*--------------------------------------------------------------------*
*                       Self-heating Parameter                       *
*--------------------------------------------------------------------*
+ cth0 = 0                        rth0 = 0
*--------------------------------------------------------------------*
*                          Noise Parameter                           *
*--------------------------------------------------------------------*
+ nlev = 0                        kf = 0                          af = 0
+ meaststep = 0                   hss = 0.01                      hmu0 = 0.01
+ hmu1 = 0.01                     hiol = 1                        hcox = 0
+ asp = 1                         bsp = 0.5                       dsp = 0.5
+ gsp = 0.5                       tsp = 10000                     asn = 0.1
+ bsn = 0.5                       dsn = 0.5                       gsn = 0.5
+ tsn = 10000
*--------------------------------------------------------------------*
*                               Other                                *
*--------------------------------------------------------------------*
+ lwdepmod = 0                    stresstimemod = 1               stressparammod = 1
+ tox2 = 0                        epsi2 = 0                       strmod = 0
+ hysadjustp = 1                  imageadjustp = 0.0001           gleveladjustp = 1
+ badjustp = 0.1                  tauadjustp = 0.0001             hysadjustn = 0.1
+ imageadjustn = 0.0001           gleveladjustn = 1               badjustn = 0.1
+ tauadjustn = 0.0001             asptemp = 0.025                 bsptemp = 1
+ tsptemp = 0.025                 asntemp = 0.025                 bsntemp = 1
+ tsntemp = 0.025                 acamplitude = 10                acexpadjust = 1
+ actau = 0.5

.model m_goa_tft.5 nmos
*--------------------------------------------------------------------*
*                           Model Selector                           *
*--------------------------------------------------------------------*
+ level = 302                     version = 2                     capmod = 0
+ shmod = 0                       geomod = 0                      tempmod = 1
+ vfbmod = 1                      leakmod = 3                     acm = 0
+ wmin = 0.0007                   wmax = 0.05                  lmin = 3.5e-06
+ lmax = 3.96E-6
*--------------------------------------------------------------------*
*                         Process Parameter                          *
*--------------------------------------------------------------------*
+ tox = 4e-07                     l = 3.5e-06                     w = 0.0007
+ eps = 11                        epsi = 6.9
*--------------------------------------------------------------------*
*                         Geometry Parameter                         *
*--------------------------------------------------------------------*
+ del = 0                         xj = 0                          ld = 0
+ wd = 0                          ldif = 0                        hdif = 0
+ xl = 9.60212e-09                xw = 1.21168e-05                geo = 0
*--------------------------------------------------------------------*
*                    Series Resistance Parameter                     *
*--------------------------------------------------------------------*
+ rd = 0.0                        rs = 0.0                        rdc = 0
+ rsc = 0                         rsh = 0
*--------------------------------------------------------------------*
*                          Id-Vd Parameter                           *
*--------------------------------------------------------------------*
+ lambda = 0.007786856986042923   wlambda = -0.3148674179985309   lambdag = 0
+ alphasat = 1.6264186942061152   walphasat = -487.15318818463726  asatg = -0
+ kink = 0                        mkink = 1.3                     vkinkg = 0
+ vkink = 9.1                     lkink = 1.9e-05                 m = 1.6694212687625951
+ wm = 1336.0512731488407
*--------------------------------------------------------------------*
*                          Id-Vg Parameter                           *
*--------------------------------------------------------------------*
+ vmin = 0.05640401703493525      wvmin = 363.21801017633646      delta = 1.6114251944762215
+ wdelta = 3994.7080657102156     delvto = 0                      muband = 3.7546597E-4
+ wmuband = 0.20344609305877595   mubandg = 0                     mubandd = 0
+ vaa = 19178.083954952548        wvaa = -6344450.780292153       gamma = 0.3329514666551914
+ wgamma = 33.65074707099839      gammad = 0
*--------------------------------------------------------------------*
*                           Vth Parameter                            *
*--------------------------------------------------------------------*
+ vt_estmod = 3                   vfb = -0.9961313361125428       wvfb = -1086.2477729158118
+ vti_max = 0                     v0 = 0.3001886950096162         wv0 = -67.62453048962385
+ gmin = 2.2487937E23             wgmin = -1.1005671E26           def0 = 0.6
+ vt0 = 3.3683848270815555        wvt0 = -348.0505234458705       dibl = 0.0111366
+ dibld = 0.1                     nibl = 0                        nibld = 2e-05
*--------------------------------------------------------------------*
*                         Leakage Parameter                          *
*--------------------------------------------------------------------*
+ iol = 5.7938525E-13             wiol = 2.3914837E-11            vdsl = 5.77298156100278
+ wvdsl = 517.0526545276953       vgsl = 11.847147530196604       wvgsl = -1948.9408629555103
+ vgsld = 0.000509651             ibcf = 0.1                      vdsbc = 0.1
+ mbc = 1                         mbcd = 0.15                     vfc = -18.7658
+ ifcf = 0.785678                 mfc = 0.032783                  mfcd = 0
+ sigma0 = 1.0E-14                sigma0d = 0.05                  ulc1a = 1e-16
+ ulc1b = 1e-15                   ulc1eaa = 0.025                 ulc1eab = 0.025
+ ulc2gamma = 1e-18               ulc2etad = 0.5                  ulc2etag = 0.15
*--------------------------------------------------------------------*
*                  Temperature Dependency Parameter                  *
*--------------------------------------------------------------------*
+ tnom = 27                       emu = 0.06                      kvt = -0.036
+ kasat = 0.006                   el = 0.35                       tvfb1 = -0.01
+ tvfb2 = 0.001                   ute = 1                         kgamma = 0.001
+ kv0 = 0.001                     kdibl = 1                       kiol = 0.01
+ ksigma0 = 0.01                  kifcf = 0.01                    kibcf = 0.01
+ tc = 390
*--------------------------------------------------------------------*
*                       Capacitance Parameter                        *
*--------------------------------------------------------------------*
+ leffcv = 1e-05                  weffcv = 1e-05                  dlc = 0
+ dwc = 0                         dvon = 0.1                      zeroc = 0
+ meto = 0                        cgso = 0.0                      cgdo = 0.0
+ capgamma = 0.5                  etac0 = 7.0                     etac00 = 0
+ mc = 3                          meascap = 0
*--------------------------------------------------------------------*
*                   Frequency Dispersion Parameter                   *
*--------------------------------------------------------------------*
+ kss = 0                         rdx = 0.0                       rsx = 0.0
*--------------------------------------------------------------------*
*                       Self-heating Parameter                       *
*--------------------------------------------------------------------*
+ cth0 = 0                        rth0 = 0
*--------------------------------------------------------------------*
*                          Noise Parameter                           *
*--------------------------------------------------------------------*
+ nlev = 0                        kf = 0                          af = 0
+ meaststep = 0                   hss = 0.01                      hmu0 = 0.01
+ hmu1 = 0.01                     hiol = 1                        hcox = 0
+ asp = 1                         bsp = 0.5                       dsp = 0.5
+ gsp = 0.5                       tsp = 10000                     asn = 0.1
+ bsn = 0.5                       dsn = 0.5                       gsn = 0.5
+ tsn = 10000
*--------------------------------------------------------------------*
*                               Other                                *
*--------------------------------------------------------------------*
+ lwdepmod = 0                    stresstimemod = 1               stressparammod = 1
+ tox2 = 0                        epsi2 = 0                       strmod = 0
+ hysadjustp = 1                  imageadjustp = 0.0001           gleveladjustp = 1
+ badjustp = 0.1                  tauadjustp = 0.0001             hysadjustn = 0.1
+ imageadjustn = 0.0001           gleveladjustn = 1               badjustn = 0.1
+ tauadjustn = 0.0001             asptemp = 0.025                 bsptemp = 1
+ tsptemp = 0.025                 asntemp = 0.025                 bsntemp = 1
+ tsntemp = 0.025                 acamplitude = 10                acexpadjust = 1
+ actau = 0.5

************************************************************
****                                     Data        Model
**** Eff. Mobility(cm2/volt/sec)     0.718902     0.729931
****                      Vth(V)      1.48993      1.44993
****  Sub-Threshold Slope(V/dec)      1.56968      1.52723
****          Ion(A) @ Vgs = 10V     1.85e-06   1.8813e-06
****        Ioff(A) @ Vgs = -10V      1.8e-11  1.54636e-11
************************************************************
