.include "../model/model.sp"
XPIX gate data pixel pixel_cell
