.model TFT_N nmos level=1
.subckt pixel_cell gate data pixel
M1 pixel gate data data TFT_N W=10u L=5u
.ends pixel_cell
